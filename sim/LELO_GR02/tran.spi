*TB_SUN_TR_SKY130NM/TB_NCM
*----------------------------------------------------------------
* Include
*----------------------------------------------------------------
#ifdef Lay
.include ../../../work/lpe/LELO_GR02_lpe.spi
#else
.include ../../../work/xsch/LELO_GR02.spice
#endif

*-----------------------------------------------------------------
* OPTIONS
*-----------------------------------------------------------------
.option TNOM=27 GMIN=1e-15 reltol=1e-3
.option sparse

*-----------------------------------------------------------------
* PARAMETERS
*-----------------------------------------------------------------
.param TRF = 10p

.param AVDD = {vdda}

*-----------------------------------------------------------------
* FORCE
*-----------------------------------------------------------------
VSS  VSS  0     dc 0
VDD  VDD_1V8  VSS  pwl 0 0 10n {AVDD}
VPWB PWRUP_1V8 VSS  pwl 0 {AVDD} {PWRUP_Off} {AVDD} {{PWRUP_Off}+ 0.1u} 0

*-----------------------------------------------------------------
* DUT
*-----------------------------------------------------------------
.include ../xdut.spi

*----------------------------------------------------------------
* PROBE
*----------------------------------------------------------------
.save i(vdd)
.save V(osc_temp_1v8)
.save v(VDD_1V8)
.save v(PWRUP_1V8)
.save v(PWRUP_N_1V8)
.save v(PWRUP_B_1V8)
.save v(xdut.oscillator_0.v_ctat)
.save v(xdut.oscillator_0.i_ptat)
.save v(xdut.oscillator_0.x6.ck)

*----------------------------------------------------------------
* NGSPICE control
*----------------------------------------------------------------
.control
set num_threads=8
set color0=white
set color1=black
unset askquit

optran 0 0 0 1n 1u 0

ptran 0 0 0 1n 1u 0

#ifdef Nosweep
tran {t_step} {t_stop}
write {cicname}.raw
#else
set fend = .raw
foreach vtemp {temperatures}
  option temp=$vtemp
  tran {t_step} {t_stop}
  write {cicname}_$vtemp$fend
end
#endif

quit

.endc

.end
