** sch_path: /home/ardiu/pro/aicex/ip/lelo_gr02_sky130a/design/LELO_GR02_SKY130A/BANDGAP_OPAMP.sch
**.subckt BANDGAP_OPAMP PWRUP_N_1V8 PWRUP_B_1V8 VSS VIN VIP VOUT VDD_1V8
*.ipin VSS
*.ipin PWRUP_N_1V8
*.ipin VIP
*.opin VOUT
*.ipin VIN
*.ipin PWRUP_B_1V8
*.ipin VDD_1V8
x10 net1 VIN net2 VSS LELOATR_LVT_NCH_4C5F0
x4 PMOS_GATE VIP net2 VSS LELOATR_LVT_NCH_4C5F0
x2<4> net1 VOUT JNWTR_CAPX4
x2<3> net1 VOUT JNWTR_CAPX4
x2<2> net1 VOUT JNWTR_CAPX4
x2<1> net1 VOUT JNWTR_CAPX4
x2<0> net1 VOUT JNWTR_CAPX4
x3<3> VOUT net1 SUPPLY VDD_1V8 LELOATR_PCH_4C5F0
x3<2> VOUT net1 SUPPLY VDD_1V8 LELOATR_PCH_4C5F0
x3<1> VOUT net1 SUPPLY VDD_1V8 LELOATR_PCH_4C5F0
x3<0> VOUT net1 SUPPLY VDD_1V8 LELOATR_PCH_4C5F0
x1<1> net2 Upper_V_IB net4<1> VSS LELOATR_LVT_NCH_4C5F0
x1<0> net2 Upper_V_IB net4<0> VSS LELOATR_LVT_NCH_4C5F0
x8<1> Upper_V_IB Upper_V_IB LOWER_V_IB VSS LELOATR_LVT_NCH_4C5F0
x8<0> Upper_V_IB Upper_V_IB LOWER_V_IB VSS LELOATR_LVT_NCH_4C5F0
x7<1> VOUT Upper_V_IB net3<1> VSS LELOATR_NCH_4C5F0
x7<0> VOUT Upper_V_IB net3<0> VSS LELOATR_NCH_4C5F0
x4<3> net1 PMOS_GATE SUPPLY VDD_1V8 LELOATR_PCH_4C5F0
x4<2> net1 PMOS_GATE SUPPLY VDD_1V8 LELOATR_PCH_4C5F0
x4<1> net1 PMOS_GATE SUPPLY VDD_1V8 LELOATR_PCH_4C5F0
x4<0> net1 PMOS_GATE SUPPLY VDD_1V8 LELOATR_PCH_4C5F0
x5<3> PMOS_GATE PMOS_GATE SUPPLY VDD_1V8 LELOATR_PCH_4C5F0
x5<2> PMOS_GATE PMOS_GATE SUPPLY VDD_1V8 LELOATR_PCH_4C5F0
x5<1> PMOS_GATE PMOS_GATE SUPPLY VDD_1V8 LELOATR_PCH_4C5F0
x5<0> PMOS_GATE PMOS_GATE SUPPLY VDD_1V8 LELOATR_PCH_4C5F0
x9 SUPPLY PWRUP_N_1V8 VDD_1V8 VDD_1V8 LELOATR_PCH_2C1F2
x6<2> LOWER_V_IB PWRUP_N_1V8 VSS VSS LELOATR_NCH_4C5F0
x6<1> LOWER_V_IB PWRUP_N_1V8 VSS VSS LELOATR_NCH_4C5F0
x6<0> LOWER_V_IB PWRUP_N_1V8 VSS VSS LELOATR_NCH_4C5F0
x1 Upper_V_IB SUPPLY VSS JNWTR_RPPO16
x9<1> net4<1> LOWER_V_IB VSS VSS LELOATR_LVT_NCH_4C5F0
x9<0> net4<0> LOWER_V_IB VSS VSS LELOATR_LVT_NCH_4C5F0
x10<1> LOWER_V_IB LOWER_V_IB VSS VSS LELOATR_LVT_NCH_4C5F0
x10<0> LOWER_V_IB LOWER_V_IB VSS VSS LELOATR_LVT_NCH_4C5F0
x11<1> net3<1> LOWER_V_IB VSS VSS LELOATR_LVT_NCH_4C5F0
x11<0> net3<0> LOWER_V_IB VSS VSS LELOATR_LVT_NCH_4C5F0
**.ends

* expanding   symbol:  LELO_ATR_SKY130A/LELOATR_LVT_NCH_4C5F0.sym # of pins=4
** sym_path: /home/ardiu/pro/aicex/ip/lelo_gr02_sky130a/design/LELO_ATR_SKY130A/LELOATR_LVT_NCH_4C5F0.sym
** sch_path: /home/ardiu/pro/aicex/ip/lelo_gr02_sky130a/design/LELO_ATR_SKY130A/LELOATR_LVT_NCH_4C5F0.sch
.subckt LELOATR_LVT_NCH_4C5F0 D G S B
*.iopin D
*.iopin G
*.iopin S
*.iopin B
XM1 D G S B sky130_fd_pr__nfet_01v8_lvt L=0.94 W=3.2 nf=2 ad='int((nf+1)/2) * W/nf * 0.29' as='int((nf+2)/2) * W/nf * 0.29' pd='2*int((nf+1)/2) * (W/nf + 0.29)'
+ ps='2*int((nf+2)/2) * (W/nf + 0.29)' nrd='0.29 / W' nrs='0.29 / W' sa=0 sb=0 sd=0 mult=1 m=1
.ends

* expanding   symbol:  JNW_TR_SKY130A/JNWTR_CAPX4.sym # of pins=2
** sym_path: /home/ardiu/pro/aicex/ip/lelo_gr02_sky130a/design/JNW_TR_SKY130A/JNWTR_CAPX4.sym
** sch_path: /home/ardiu/pro/aicex/ip/lelo_gr02_sky130a/design/JNW_TR_SKY130A/JNWTR_CAPX4.sch
.subckt JNWTR_CAPX4 A B
*.iopin A
*.iopin B
XXA1 A B JNWTR_CAPX1
XXA2 A B JNWTR_CAPX1
XXB1 A B JNWTR_CAPX1
XXB2 A B JNWTR_CAPX1
.ends

* expanding   symbol:  LELO_ATR_SKY130A/LELOATR_PCH_4C5F0.sym # of pins=4
** sym_path: /home/ardiu/pro/aicex/ip/lelo_gr02_sky130a/design/LELO_ATR_SKY130A/LELOATR_PCH_4C5F0.sym
** sch_path: /home/ardiu/pro/aicex/ip/lelo_gr02_sky130a/design/LELO_ATR_SKY130A/LELOATR_PCH_4C5F0.sch
.subckt LELOATR_PCH_4C5F0 D G S B
*.iopin D
*.iopin G
*.iopin S
*.iopin B
XM1 D G S B sky130_fd_pr__pfet_01v8 L=0.94 W=3.2 nf=2 ad='int((nf+1)/2) * W/nf * 0.29' as='int((nf+2)/2) * W/nf * 0.29' pd='2*int((nf+1)/2) * (W/nf + 0.29)'
+ ps='2*int((nf+2)/2) * (W/nf + 0.29)' nrd='0.29 / W' nrs='0.29 / W' sa=0 sb=0 sd=0 mult=1 m=1
.ends

* expanding   symbol:  LELO_ATR_SKY130A/LELOATR_NCH_4C5F0.sym # of pins=4
** sym_path: /home/ardiu/pro/aicex/ip/lelo_gr02_sky130a/design/LELO_ATR_SKY130A/LELOATR_NCH_4C5F0.sym
** sch_path: /home/ardiu/pro/aicex/ip/lelo_gr02_sky130a/design/LELO_ATR_SKY130A/LELOATR_NCH_4C5F0.sch
.subckt LELOATR_NCH_4C5F0 D G S B
*.iopin D
*.iopin G
*.iopin S
*.iopin B
XM1 D G S B sky130_fd_pr__nfet_01v8 L=0.94 W=3.2 nf=2 ad='int((nf+1)/2) * W/nf * 0.29' as='int((nf+2)/2) * W/nf * 0.29' pd='2*int((nf+1)/2) * (W/nf + 0.29)'
+ ps='2*int((nf+2)/2) * (W/nf + 0.29)' nrd='0.29 / W' nrs='0.29 / W' sa=0 sb=0 sd=0 mult=1 m=1
.ends

* expanding   symbol:  LELO_ATR_SKY130A/LELOATR_PCH_2C1F2.sym # of pins=4
** sym_path: /home/ardiu/pro/aicex/ip/lelo_gr02_sky130a/design/LELO_ATR_SKY130A/LELOATR_PCH_2C1F2.sym
** sch_path: /home/ardiu/pro/aicex/ip/lelo_gr02_sky130a/design/LELO_ATR_SKY130A/LELOATR_PCH_2C1F2.sch
.subckt LELOATR_PCH_2C1F2 D G S B
*.iopin D
*.iopin G
*.iopin S
*.iopin B
XM1 D G S B sky130_fd_pr__pfet_01v8 L=0.22 W=1.92 nf=2 ad='int((nf+1)/2) * W/nf * 0.29' as='int((nf+2)/2) * W/nf * 0.29' pd='2*int((nf+1)/2) * (W/nf + 0.29)'
+ ps='2*int((nf+2)/2) * (W/nf + 0.29)' nrd='0.29 / W' nrs='0.29 / W' sa=0 sb=0 sd=0 mult=1 m=1
.ends

* expanding   symbol:  JNW_TR_SKY130A/JNWTR_RPPO16.sym # of pins=3
** sym_path: /home/ardiu/pro/aicex/ip/lelo_gr02_sky130a/design/JNW_TR_SKY130A/JNWTR_RPPO16.sym
** sch_path: /home/ardiu/pro/aicex/ip/lelo_gr02_sky130a/design/JNW_TR_SKY130A/JNWTR_RPPO16.sch
.subckt JNWTR_RPPO16 N P B
*.iopin P
*.iopin N
*.iopin B
XXA1 N P B JNWTR_RES16
.ends

* expanding   symbol:  JNW_TR_SKY130A/JNWTR_CAPX1.sym # of pins=2
** sym_path: /home/ardiu/pro/aicex/ip/lelo_gr02_sky130a/design/JNW_TR_SKY130A/JNWTR_CAPX1.sym
** sch_path: /home/ardiu/pro/aicex/ip/lelo_gr02_sky130a/design/JNW_TR_SKY130A/JNWTR_CAPX1.sch
.subckt JNWTR_CAPX1 A B
*.iopin A
*.iopin B
XC1 B A sky130_fd_pr__cap_mim_m3_1 W=5 L=5 MF=1 m=1
.ends

* expanding   symbol:  JNW_TR_SKY130A/JNWTR_RES16.sym # of pins=3
** sym_path: /home/ardiu/pro/aicex/ip/lelo_gr02_sky130a/design/JNW_TR_SKY130A/JNWTR_RES16.sym
** sch_path: /home/ardiu/pro/aicex/ip/lelo_gr02_sky130a/design/JNW_TR_SKY130A/JNWTR_RES16.sch
.subckt JNWTR_RES16 N P B
*.iopin N
*.iopin P
*.iopin B
XR1_0 INT_0 N B sky130_fd_pr__res_high_po W=0.36 L=7.36 mult=1 m=1
XR1_1 INT_1 INT_0 B sky130_fd_pr__res_high_po W=0.36 L=7.36 mult=1 m=1
XR1_2 INT_2 INT_1 B sky130_fd_pr__res_high_po W=0.36 L=7.36 mult=1 m=1
XR1_3 INT_3 INT_2 B sky130_fd_pr__res_high_po W=0.36 L=7.36 mult=1 m=1
XR1_4 INT_4 INT_3 B sky130_fd_pr__res_high_po W=0.36 L=7.36 mult=1 m=1
XR1_5 INT_5 INT_4 B sky130_fd_pr__res_high_po W=0.36 L=7.36 mult=1 m=1
XR1_6 INT_6 INT_5 B sky130_fd_pr__res_high_po W=0.36 L=7.36 mult=1 m=1
XR1_7 INT_7 INT_6 B sky130_fd_pr__res_high_po W=0.36 L=7.36 mult=1 m=1
XR1_8 INT_8 INT_7 B sky130_fd_pr__res_high_po W=0.36 L=7.36 mult=1 m=1
XR1_9 INT_9 INT_8 B sky130_fd_pr__res_high_po W=0.36 L=7.36 mult=1 m=1
XR1_10 INT_10 INT_9 B sky130_fd_pr__res_high_po W=0.36 L=7.36 mult=1 m=1
XR1_11 INT_11 INT_10 B sky130_fd_pr__res_high_po W=0.36 L=7.36 mult=1 m=1
XR1_12 INT_12 INT_11 B sky130_fd_pr__res_high_po W=0.36 L=7.36 mult=1 m=1
XR1_13 INT_13 INT_12 B sky130_fd_pr__res_high_po W=0.36 L=7.36 mult=1 m=1
XR1_14 INT_14 INT_13 B sky130_fd_pr__res_high_po W=0.36 L=7.36 mult=1 m=1
XR1_15 P INT_14 B sky130_fd_pr__res_high_po W=0.36 L=7.36 mult=1 m=1
.ends

.end
